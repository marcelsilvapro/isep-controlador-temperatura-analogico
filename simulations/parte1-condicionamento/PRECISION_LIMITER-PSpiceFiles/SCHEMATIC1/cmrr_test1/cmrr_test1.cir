** Profile: "SCHEMATIC1-cmrr_test1"  [ c:\users\danie\documents\precision_limiter\precision_limiter-PSpiceFiles\SCHEMATIC1\cmrr_test1.sim ]

** Creating circuit file "cmrr_test1.cir"
** WARNING: THIS AUTOMATICALLY GENERATED FILE MAY BE OVERWRITTEN BY SUBSEQUENT SIMULATIONS

*Libraries:
* Profile Libraries :
* Local Libraries :
.LIB "../../../precision_limiter-pspicefiles/schematic1/monte_carlo/tolerance.lib"
* From [PSPICE NETLIST] section of C:\cds_spb_home\cdssetup\OrCAD_PSpiceTIPSpice_Install\23.1.0\PSpice.ini file:
.lib "nom.lib"
.lib "nom_pspti.lib"

*Analysis directives:
.DC LIN V_V5 2 10 0.5
.OPTIONS ADVCONV
.OPTIONS FILEMODELSEARCH
.PROBE64 V(alias(*)) I(alias(*)) W(alias(*)) D(alias(*)) NOISE(alias(*))
.INC "..\SCHEMATIC1.net"

.END
